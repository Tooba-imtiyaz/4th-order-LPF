.title LPF_4th_Order_Migration
Vv2 VCC GND dc 12
Vv3 GND VEE dc 12
Vv1 IN GND ac 1 0
R1 IN N1 27k
R2 N1 N2 27k
C1 N2 N3 0.1u
C2 N3 GND 0.1u
C3 N1 N4 0.1u
Rbias1 N3 GND 100Meg
XU1 N2 N4 VCC VEE N4 LM324
RVR1 N4 N5 22k
R3 N5 N6 27k
R4 GND N7 9.1k
R5 N7 OUT 15k
C4 N6 GND 0.1u
C5 N5 OUT 0.1u
Rbias2 N6 GND 100Meg
XU2 N6 N7 VCC VEE OUT LM324
.subckt LM324 INP INM VCC VEE OUT
Rin INP INM 10Meg
Rip INP GND 1000Meg
Rim INM GND 1000Meg
Eout EOUT GND INP INM 100k
Rser EOUT OUT 100
Rvcc VCC GND 1000Meg
Rvee VEE GND 1000Meg
.ends LM324
.options reltol=1e-3 abstol=1e-6
.end
